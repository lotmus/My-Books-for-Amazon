* 2N7000 level-1 fit from three datasheet typicals
.model M7000 NMOS(Level=1 Vto=2.01 Kp=0.256 Lambda=0)
.options TNOM=27
VG g 0 2.1
VD d 0 2.1
RD d dd 0.71
M1 dd g 0 0 M7000 W=1 L=1
.control
op
print -i(VD)
alter VG dc=10
alter VD dc=0.6
op
print v(d)/(-i(VD))
alter VG dc=4.5
alter VD dc=0.14
op
print v(d)/(-i(VD))
alter VG dc=4.5
alter VD dc=10
op
print -i(VD)
quit
.endc
.end
