* 1N4148 library model, forward sweep for Figure 23.1
.model D1N4148 D(Is=2.52n Rs=0.568 N=1.752 Cjo=4p M=0.4 Tt=20n)
.options TNOM=27
.temp 27
V1 a 0 0.5
D1 a 0 D1N4148
.control
dc V1 0.30 1.05 0.002
let id=-i(V1)
wrdata d1n4148_iv.txt id
quit
.endc
.end
