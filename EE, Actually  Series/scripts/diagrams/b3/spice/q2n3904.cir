* 2N3904 Gummel-Poon library model: hFE vs IC at VCE = 1 V
.model Q2N3904 NPN(Is=6.734f Xti=3 Eg=1.11 Vaf=74.03 Bf=416.4 Ne=1.259 Ise=6.734f Ikf=66.78m Xtb=1.5 Br=.7371 Nc=2 Isc=0 Ikr=0 Rc=1 Cjc=3.638p Mjc=.3085 Vjc=.75 Fc=.5 Cje=4.493p Mje=.2593 Vje=.75 Tr=239.5n Tf=301.2p Itf=.4 Vtf=4 Xtf=2 Rb=10)
.options TNOM=27
.temp 27
VC c 0 1
VB b 0 0.6
Q1 c b 0 Q2N3904
.control
dc VB 0.40 0.95 0.001
let ic=-i(VC)
 let ib=-i(VB)
 wrdata gummel.txt ic ib
quit
.endc
.end
